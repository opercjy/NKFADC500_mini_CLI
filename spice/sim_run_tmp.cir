* Hamamatsu H7195 (-1700V) -> RG-58 (50 Ohm) -> NKFADC500 Mini Ch0 (50 Ohm AFE)
.title H7195_NKFADC500_Transient_Simulation

* 1. H7195 Anode Current Source (Bi-exponential fast + liquid scintillator slow component)
* In ngspice EXP(0 I0 TD1 TAU_R TD1 TAU_D): I(t) = I0 * (exp(-(t-TD1)/TAU_D) - exp(-(t-TD1)/TAU_R))
I_FAST n_anode 0 EXP(0 2.08282962e-02 353.5n 1.65n 353.5n 3.6n)
I_SLOW n_anode 0 EXP(0 3.77448532e-04 353.5n 1.65n 353.5n 32.0n)

* 2. H7195 Anode Parasitics & Base Network (R_a=100k, C_a=6.0pF, L_lead=4.5nH, R_damp=22 Ohm)
R_ANODE n_anode 0 100k
C_ANODE n_anode 0 6.0p
L_LEAD  n_anode n_damp 4.5n
R_DAMP  n_damp  n_bnc_tx 22.0
R_BACK  n_bnc_tx 0 1.0000e+08

* 3. RG-58 C/U Coaxial Cable (Z0 = 50.0 Ohm, TD = 15.0 ns for 3m cable)
T_RG58  n_bnc_tx 0 n_bnc_rx 0 Z0=50.0 TD=15.0n

* 4. Notice Korea NKFADC500 Mini Ch0 Front-End (R_term = 50.0 Ohm + Buffered 225 MHz Bessel AFE)
R_TERM  n_bnc_rx 0 50.0
C_IN    n_bnc_rx 0 3.5p
E_BUF   n_buf    0 n_bnc_rx 0 1.0
R_AFE   n_buf    n_afe1 50.0
L_AFE   n_afe1   n_adc_in 15.0n
C_AFE   n_adc_in 0 6.0p
R_ADC   n_adc_in 0 100k

.tran 0.1n 992.0n 0.0n 0.1n

.control
set wr_singlescale
set wr_vecnames
run
wrdata /home/cpnrdaq4/NKFADC500_mini_CLI/spice/sim_out_tmp.txt v(n_anode) v(n_bnc_tx) v(n_bnc_rx) v(n_adc_in)
quit
.endc
.end
