* ==============================================================================
* Hamamatsu H7195 (R329-02 12-Stage PMT + E2979-500 Voltage Divider Assembly)
* Full 12-Stage Dynode Equivalent Circuit with Inter-Electrode Parasitics
* -> RG-58 C/U (50 Ohm, 15 ns) -> Notice Korea NKFADC500 Mini Ch0 (50 Ohm AFE)
* ==============================================================================
.title H7195_12Stage_Dynode_Parasitics_to_NKFADC500_Mini

* --- 1. High-Voltage Supply & Bleeder Divider Chain (E2979-500 Ratio) ---
* Tapered resistor ratio K : DY1 : F : DY2..DY8 : DY9 : DY10 : DY11 : DY12 : GND
* = 2.2 : 1.0 : 1.2 : 1.0(x6) : 1.2 : 1.5 : 2.2 : 3.0 : 2.6 (Unit R0 = 160 kOhm, R_tot = 3.184 MOhm)
V_HV    n_k     0   DC -1700.0
R_K_D1  n_k     n_dy1   352k
R_D1_F  n_dy1   n_foc   160k
R_F_D2  n_foc   n_dy2   192k
R_D2_8  n_dy2   n_dy8   960k
R_D8_9  n_dy8   n_dy9   192k
R_D9_10 n_dy9   n_dy10  240k
R_D10_11 n_dy10 n_dy11  352k
R_D11_12 n_dy11 n_dy12  480k
R_D12_G  n_dy12 0       416k

* --- 2. Last-Stage Decoupling Capacitors + Parasitic ESL & ESR ---
* C_DEC9..12 stabilize dynode voltages during high-current pulses, but their
* lead inductance (L_ESL) + PMT stem wire inductance (L_STEM) form a ~125 MHz
* (T = 8.0 ns) parasitic LC tank with inter-dynode/anode capacitances.
C_DEC9   n_dy9   n_esl9  10n
R_ESR9   n_esl9  n_esl9b 0.8
L_ESL9   n_esl9b 0       10n
C_DEC10  n_dy10  n_esl10 10n
R_ESR10  n_esl10 n_esl10b 0.8
L_ESL10  n_esl10b 0      10n
C_DEC11  n_dy11  n_esl11 10n
R_ESR11  n_esl11 n_esl11b 0.8
L_ESL11  n_esl11b 0      12n
C_DEC12  n_dy12  n_esl12 10n
R_ESR12  n_esl12 n_esl12b 0.6
L_ESL12  n_esl12b 0      12n

* Internal PMT vacuum-stem lead inductance (L_STEM12 = 48 nH) between external
* socket pin (n_dy12, where C_DEC12 sits) and internal 12th dynode plate (n_dy12_int)
* Together with L_ESL12 (12 nH) and C_DY12_eq (~27.0 pF), f_ring = 1/(2*pi*sqrt(60nH*27pF)) = 125.0 MHz (T = 8.0 ns)!
R_STEM12 n_dy12   n_dy12_s   6.5
L_STEM12 n_dy12_s n_dy12_int 48.0n
C_DY12_V n_dy12_int 0        19.5p

* --- 3. Inter-Electrode Parasitic Capacitances (DY10-DY11-DY12-Anode Stem) ---
C_D10_11 n_dy10  n_dy11      3.2p
C_D11_12 n_dy11  n_dy12_int  3.5p
C_D12_A  n_dy12_int n_anode  4.0p
C_A_GND  n_anode 0           4.0p
R_ANODE  n_anode 0           100k

* --- 4. Coupled Dynode & Anode Avalanche Current Sources (Operating @ -1700 V) ---
* At V_HV = -1700 V: Gain G(-1700V) = 8.16e5 (24.72% of nominal G(-2000V)=3.30e6),
* Collection efficiency eta_coll(-1700V) = 86.9% (96.54% of nominal 90.0%).
* Last-stage secondary emission factor delta_12 = 3.55 -> DY12 net positive current
* is +(1 - 1/delta_12) * I_anode = +0.718 * I_anode.
.param I0_FAST = 2.45e-3
.param I0_SLOW = 7.50e-5
.param T_START = 354.3n
.param TAU_R   = 1.65n
.param TAU_DF  = 3.60n
.param TAU_DS  = 32.0n

* Anode negative electron collection current (flows out of n_anode to 0)
I_A_FAST n_anode 0 EXP(0 {I0_FAST} {T_START} {TAU_R} {T_START} {TAU_DF})
I_A_SLOW n_anode 0 EXP(0 {I0_SLOW} {T_START} {TAU_R} {T_START} {TAU_DS})

* DY12 space-charge & secondary emission transient current
I_D12_FAST n_dy12_int 0 EXP(0 {0.718 * I0_FAST} {T_START + 1.2n} {TAU_R} {T_START + 1.2n} {TAU_DF})
I_D12_SLOW n_dy12_int 0 EXP(0 {0.718 * I0_SLOW} {T_START + 1.2n} {TAU_R} {T_START + 1.2n} {TAU_DS})

* DY11 transient current
I_D11_FAST n_dy11 0 EXP(0 {0.202 * I0_FAST} {T_START + 0.4n} {TAU_R} {T_START + 0.4n} {TAU_DF})

* --- 5. Anode Stem Inductance, Base Output Network & RG-58 Coaxial Line ---
L_STEM_A n_anode n_damp  14.0n
R_DAMP_A n_damp  n_bnc_tx 22.0
T_RG58   n_bnc_tx 0 n_bnc_rx 0 Z0=50.0 TD=15.0n

* --- 6. Notice Korea NKFADC500 Mini Ch0 Front-End (50 Ohm + 225 MHz Bessel AFE) ---
R_TERM   n_bnc_rx 0 50.0
C_IN     n_bnc_rx 0 2.0p
E_BUF    n_buf    0 n_bnc_rx 0 1.0
R_AFE    n_buf    n_afe1 50.0
L_AFE    n_afe1   n_adc_in 15.0n
C_AFE    n_adc_in 0 6.0p
R_ADC    n_adc_in 0 100k

.tran 0.05n 992.0n 0.0n 0.05n

.control
set wr_singlescale
set wr_vecnames
run
wrdata spice/h7195_12stage_out.txt v(n_anode) v(n_dy12_int) v(n_bnc_tx) v(n_bnc_rx) v(n_adc_in)
quit
.endc
.end
