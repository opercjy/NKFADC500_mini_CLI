* Hamamatsu H7195 12-Stage Dynode + Parasitics -> RG-58 -> NKFADC500 Mini Ch0
.title H7195_12Stage_Dynode_NKFADC500_Simulation

* 1. High-Voltage Supply (-1700.0 V) & 12-Stage Bleeder Chain (E2979-500)
V_HV     n_k      0       DC -1700.00
R_K_D1   n_k      n_dy1   352k
R_D1_F   n_dy1    n_foc   160k
R_F_D2   n_foc    n_dy2   192k
R_D2_8   n_dy2    n_dy8   960k
R_D8_9   n_dy8    n_dy9   192k
R_D9_10  n_dy9    n_dy10  240k
R_D10_11 n_dy10   n_dy11  352k
R_D11_12 n_dy11   n_dy12  480k
R_D12_G  n_dy12   0       416k

* 2. Last-Stages Decoupling Capacitors (C_DEC9..12) with Parasitic ESL & ESR
C_DEC9   n_dy9    n_esl9  10n
R_ESR9   n_esl9   n_esl9b 0.8
L_ESL9   n_esl9b  0       10n
C_DEC10  n_dy10   n_esl10 10n
R_ESR10  n_esl10  n_esl10b 0.8
L_ESL10  n_esl10b 0       10n
C_DEC11  n_dy11   n_esl11 10n
R_ESR11  n_esl11  n_esl11b 0.8
L_ESL11  n_esl11b 0       12n
C_DEC12  n_dy12   n_esl12 10n
R_ESR12  n_esl12  n_esl12b 0.6
L_ESL12  n_esl12b 0       12n

* Internal PMT Stem Lead Inductance (L_STEM12 = 48 nH) & Vacuum Stray Capacitance
* Resonates with L_ESL12 (12 nH) and C_DY12_eq (~27 pF) at f_ring = 125 MHz (T = 8.0 ns)
R_STEM12 n_dy12   n_dy12_s   50.0
L_STEM12 n_dy12_s n_dy12_int 0.1n
C_DY12_V n_dy12_int 0        19.5p

* 3. Inter-Electrode Parasitic Capacitances (DY10-DY11-DY12-Anode)
C_D10_11 n_dy10     n_dy11     3.2p
C_D11_12 n_dy11     n_dy12_int 0.001p
C_D12_A  n_dy12_int n_anode    0.001p
C_A_GND  n_anode    0          4.0p
R_ANODE  n_anode    0          100k

* 4. Coupled Anode & Dynode Avalanche Current Sources
I_A_FAST   n_anode    0 EXP(0 2.61353823e-03 353.5n 1.65n 353.5n 3.6n)
I_A_SLOW   n_anode    0 EXP(0 4.73623074e-05 353.5n 1.65n 353.5n 32.0n)
I_D12_FAST n_dy12_int 0 EXP(0 0.00000000e+00 354.7n 1.65n 354.7n 3.6n)
I_D12_SLOW n_dy12_int 0 EXP(0 0.00000000e+00 354.7n 1.65n 354.7n 32.0n)
I_D11_FAST n_dy11     0 EXP(0 0.00000000e+00 353.9n 1.65n 353.9n 3.6n)

* 5. Anode Stem Inductance, Damping & RG-58 Coaxial Transmission Line (50 Ohm, 15 ns)
L_STEM_A n_anode  n_damp   14.0n
R_DAMP_A n_damp   n_bnc_tx 22.0
T_RG58   n_bnc_tx 0 n_bnc_rx 0 Z0=50.0 TD=15.0n

* 6. Notice Korea NKFADC500 Mini Ch0 Front-End (50 Ohm Termination + 225 MHz Bessel AFE)
R_TERM   n_bnc_rx 0 50.0
C_IN     n_bnc_rx 0 2.0p
E_BUF    n_buf    0 n_bnc_rx 0 1.0
R_AFE    n_buf    n_afe1 50.0
L_AFE    n_afe1   n_adc_in 15.0n
C_AFE    n_adc_in 0 6.0p
R_ADC    n_adc_in 0 100k

.tran 0.1n 992.0n 0.0n 0.1n

.control
set wr_singlescale
set wr_vecnames
run
wrdata /home/cpnrdaq4/NKFADC500_mini_CLI/spice/sim_12stage_tmp.txt v(n_anode) v(n_dy12_int) v(n_bnc_tx) v(n_bnc_rx) v(n_adc_in) v(n_dy1) v(n_dy11)
quit
.endc
.end
